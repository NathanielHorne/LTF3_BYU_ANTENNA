# Ansys Electronics Desktop project, version 2021.2
materials:
  vacuum: permittivity=1
  FR408: permittivity=3.68
  pec: conductivity=1e+30
  PMLGroup1_Z_1: permittivity{anisotropic component1=1.3257516 component2=1.3257516 component3=0.37714455} permeability{anisotropic component1=1.3257516 component2=1.3257516 component3=0.37714455} dielectric_loss_tangent{anisotropic component1=1 component2=1 component3=-1} magnetic_loss_tangent{anisotropic component1=1 component2=1 component3=-1}
  PMLGroup1_XZ_1: permittivity{anisotropic component1=1 component2=0.01 component3=1} permeability{anisotropic component1=1 component2=0.01 component3=1} dielectric_loss_tangent{anisotropic component1=0 component2=351.52347 component3=0} magnetic_loss_tangent{anisotropic component1=0 component2=351.52347 component3=0}
  PMLGroup1_YZ_1: permittivity{anisotropic component1=0.01 component2=1 component3=1} permeability{anisotropic component1=0.01 component2=1 component3=1} dielectric_loss_tangent{anisotropic component1=351.52347 component2=0 component3=0} magnetic_loss_tangent{anisotropic component1=351.52347 component2=0 component3=0}
  PMLGroup1_XYZ_1: permittivity{anisotropic component1=1.3257516 component2=1.3257516 component3=1.3257516} permeability{anisotropic component1=1.3257516 component2=1.3257516 component3=1.3257516} dielectric_loss_tangent{anisotropic component1=1 component2=1 component3=1} magnetic_loss_tangent{anisotropic component1=1 component2=1 component3=1}
  PMLGroup1_Z_2: permittivity{anisotropic component1=1.3257516 component2=1.3257516 component3=0.37714455} permeability{anisotropic component1=1.3257516 component2=1.3257516 component3=0.37714455} dielectric_loss_tangent{anisotropic component1=1 component2=1 component3=-1} magnetic_loss_tangent{anisotropic component1=1 component2=1 component3=-1}
  PMLGroup1_XZ_2: permittivity{anisotropic component1=1 component2=0.01 component3=1} permeability{anisotropic component1=1 component2=0.01 component3=1} dielectric_loss_tangent{anisotropic component1=0 component2=351.52347 component3=0} magnetic_loss_tangent{anisotropic component1=0 component2=351.52347 component3=0}
  PMLGroup1_YZ_2: permittivity{anisotropic component1=0.01 component2=1 component3=1} permeability{anisotropic component1=0.01 component2=1 component3=1} dielectric_loss_tangent{anisotropic component1=351.52347 component2=0 component3=0} magnetic_loss_tangent{anisotropic component1=351.52347 component2=0 component3=0}
  PMLGroup1_XYZ_2: permittivity{anisotropic component1=1.3257516 component2=1.3257516 component3=1.3257516} permeability{anisotropic component1=1.3257516 component2=1.3257516 component3=1.3257516} dielectric_loss_tangent{anisotropic component1=1 component2=1 component3=1} magnetic_loss_tangent{anisotropic component1=1 component2=1 component3=1}
  PMLGroup1_Z_3: permittivity{anisotropic component1=1.3257516 component2=1.3257516 component3=0.37714455} permeability{anisotropic component1=1.3257516 component2=1.3257516 component3=0.37714455} dielectric_loss_tangent{anisotropic component1=1 component2=1 component3=-1} magnetic_loss_tangent{anisotropic component1=1 component2=1 component3=-1}
  PMLGroup1_XZ_3: permittivity{anisotropic component1=1 component2=0.01 component3=1} permeability{anisotropic component1=1 component2=0.01 component3=1} dielectric_loss_tangent{anisotropic component1=0 component2=351.52347 component3=0} magnetic_loss_tangent{anisotropic component1=0 component2=351.52347 component3=0}
  PMLGroup1_YZ_3: permittivity{anisotropic component1=0.01 component2=1 component3=1} permeability{anisotropic component1=0.01 component2=1 component3=1} dielectric_loss_tangent{anisotropic component1=351.52347 component2=0 component3=0} magnetic_loss_tangent{anisotropic component1=351.52347 component2=0 component3=0}
  PMLGroup1_XYZ_3: permittivity{anisotropic component1=1.3257516 component2=1.3257516 component3=1.3257516} permeability{anisotropic component1=1.3257516 component2=1.3257516 component3=1.3257516} dielectric_loss_tangent{anisotropic component1=1 component2=1 component3=1} magnetic_loss_tangent{anisotropic component1=1 component2=1 component3=1}
  PMLGroup1_Z_4: permittivity{anisotropic component1=1.3257516 component2=1.3257516 component3=0.37714455} permeability{anisotropic component1=1.3257516 component2=1.3257516 component3=0.37714455} dielectric_loss_tangent{anisotropic component1=1 component2=1 component3=-1} magnetic_loss_tangent{anisotropic component1=1 component2=1 component3=-1}
  PMLGroup1_XZ_4: permittivity{anisotropic component1=1 component2=0.01 component3=1} permeability{anisotropic component1=1 component2=0.01 component3=1} dielectric_loss_tangent{anisotropic component1=0 component2=351.52347 component3=0} magnetic_loss_tangent{anisotropic component1=0 component2=351.52347 component3=0}
  PMLGroup1_YZ_4: permittivity{anisotropic component1=0.01 component2=1 component3=1} permeability{anisotropic component1=0.01 component2=1 component3=1} dielectric_loss_tangent{anisotropic component1=351.52347 component2=0 component3=0} magnetic_loss_tangent{anisotropic component1=351.52347 component2=0 component3=0}
  PMLGroup1_XYZ_4: permittivity{anisotropic component1=1.3257516 component2=1.3257516 component3=1.3257516} permeability{anisotropic component1=1.3257516 component2=1.3257516 component3=1.3257516} dielectric_loss_tangent{anisotropic component1=1 component2=1 component3=1} magnetic_loss_tangent{anisotropic component1=1 component2=1 component3=1}
  PMLGroup1_Z_5: permittivity{anisotropic component1=1.3257516 component2=1.3257516 component3=0.37714455} permeability{anisotropic component1=1.3257516 component2=1.3257516 component3=0.37714455} dielectric_loss_tangent{anisotropic component1=1 component2=1 component3=-1} magnetic_loss_tangent{anisotropic component1=1 component2=1 component3=-1}
  PMLGroup1_XZ_5: permittivity{anisotropic component1=1 component2=0.01 component3=1} permeability{anisotropic component1=1 component2=0.01 component3=1} dielectric_loss_tangent{anisotropic component1=0 component2=351.52347 component3=0} magnetic_loss_tangent{anisotropic component1=0 component2=351.52347 component3=0}
  PMLGroup1_YZ_5: permittivity{anisotropic component1=0.01 component2=1 component3=1} permeability{anisotropic component1=0.01 component2=1 component3=1} dielectric_loss_tangent{anisotropic component1=351.52347 component2=0 component3=0} magnetic_loss_tangent{anisotropic component1=351.52347 component2=0 component3=0}
  PMLGroup1_XYZ_5: permittivity{anisotropic component1=1.3257516 component2=1.3257516 component3=1.3257516} permeability{anisotropic component1=1.3257516 component2=1.3257516 component3=1.3257516} dielectric_loss_tangent{anisotropic component1=1 component2=1 component3=1} magnetic_loss_tangent{anisotropic component1=1 component2=1 component3=1}
  PMLGroup1_Z_6: permittivity{anisotropic component1=1.3257516 component2=1.3257516 component3=0.37714455} permeability{anisotropic component1=1.3257516 component2=1.3257516 component3=0.37714455} dielectric_loss_tangent{anisotropic component1=1 component2=1 component3=-1} magnetic_loss_tangent{anisotropic component1=1 component2=1 component3=-1}
  PMLGroup1_XZ_6: permittivity{anisotropic component1=1 component2=0.01 component3=1} permeability{anisotropic component1=1 component2=0.01 component3=1} dielectric_loss_tangent{anisotropic component1=0 component2=351.52347 component3=0} magnetic_loss_tangent{anisotropic component1=0 component2=351.52347 component3=0}
  PMLGroup1_YZ_6: permittivity{anisotropic component1=0.01 component2=1 component3=1} permeability{anisotropic component1=0.01 component2=1 component3=1} dielectric_loss_tangent{anisotropic component1=351.52347 component2=0 component3=0} magnetic_loss_tangent{anisotropic component1=351.52347 component2=0 component3=0}
  PMLGroup1_XYZ_6: permittivity{anisotropic component1=1.3257516 component2=1.3257516 component3=1.3257516} permeability{anisotropic component1=1.3257516 component2=1.3257516 component3=1.3257516} dielectric_loss_tangent{anisotropic component1=1 component2=1 component3=1} magnetic_loss_tangent{anisotropic component1=1 component2=1 component3=1}
  PMLGroup1_Z_7: permittivity{anisotropic component1=1.3257516 component2=1.3257516 component3=0.37714455} permeability{anisotropic component1=1.3257516 component2=1.3257516 component3=0.37714455} dielectric_loss_tangent{anisotropic component1=1 component2=1 component3=-1} magnetic_loss_tangent{anisotropic component1=1 component2=1 component3=-1}
  PMLGroup1_XZ_7: permittivity{anisotropic component1=1 component2=0.01 component3=1} permeability{anisotropic component1=1 component2=0.01 component3=1} dielectric_loss_tangent{anisotropic component1=0 component2=351.52347 component3=0} magnetic_loss_tangent{anisotropic component1=0 component2=351.52347 component3=0}
  PMLGroup1_YZ_7: permittivity{anisotropic component1=0.01 component2=1 component3=1} permeability{anisotropic component1=0.01 component2=1 component3=1} dielectric_loss_tangent{anisotropic component1=351.52347 component2=0 component3=0} magnetic_loss_tangent{anisotropic component1=351.52347 component2=0 component3=0}
  PMLGroup1_XYZ_7: permittivity{anisotropic component1=1.3257516 component2=1.3257516 component3=1.3257516} permeability{anisotropic component1=1.3257516 component2=1.3257516 component3=1.3257516} dielectric_loss_tangent{anisotropic component1=1 component2=1 component3=1} magnetic_loss_tangent{anisotropic component1=1 component2=1 component3=1}
  PMLGroup1_Z_8: permittivity{anisotropic component1=1.3257516 component2=1.3257516 component3=0.37714455} permeability{anisotropic component1=1.3257516 component2=1.3257516 component3=0.37714455} dielectric_loss_tangent{anisotropic component1=1 component2=1 component3=-1} magnetic_loss_tangent{anisotropic component1=1 component2=1 component3=-1}
  PMLGroup1_XZ_8: permittivity{anisotropic component1=1 component2=0.01 component3=1} permeability{anisotropic component1=1 component2=0.01 component3=1} dielectric_loss_tangent{anisotropic component1=0 component2=351.52347 component3=0} magnetic_loss_tangent{anisotropic component1=0 component2=351.52347 component3=0}
  PMLGroup1_YZ_8: permittivity{anisotropic component1=0.01 component2=1 component3=1} permeability{anisotropic component1=0.01 component2=1 component3=1} dielectric_loss_tangent{anisotropic component1=351.52347 component2=0 component3=0} magnetic_loss_tangent{anisotropic component1=351.52347 component2=0 component3=0}
  PMLGroup1_XYZ_8: permittivity{anisotropic component1=1.3257516 component2=1.3257516 component3=1.3257516} permeability{anisotropic component1=1.3257516 component2=1.3257516 component3=1.3257516} dielectric_loss_tangent{anisotropic component1=1 component2=1 component3=1} magnetic_loss_tangent{anisotropic component1=1 component2=1 component3=1}
  PMLGroup1_Z_9: permittivity{anisotropic component1=1.3257516 component2=1.3257516 component3=0.37714455} permeability{anisotropic component1=1.3257516 component2=1.3257516 component3=0.37714455} dielectric_loss_tangent{anisotropic component1=1 component2=1 component3=-1} magnetic_loss_tangent{anisotropic component1=1 component2=1 component3=-1}
  PMLGroup1_XZ_9: permittivity{anisotropic component1=1 component2=0.01 component3=1} permeability{anisotropic component1=1 component2=0.01 component3=1} dielectric_loss_tangent{anisotropic component1=0 component2=351.52347 component3=0} magnetic_loss_tangent{anisotropic component1=0 component2=351.52347 component3=0}
  PMLGroup1_YZ_9: permittivity{anisotropic component1=0.01 component2=1 component3=1} permeability{anisotropic component1=0.01 component2=1 component3=1} dielectric_loss_tangent{anisotropic component1=351.52347 component2=0 component3=0} magnetic_loss_tangent{anisotropic component1=351.52347 component2=0 component3=0}
  PMLGroup1_XYZ_9: permittivity{anisotropic component1=1.3257516 component2=1.3257516 component3=1.3257516} permeability{anisotropic component1=1.3257516 component2=1.3257516 component3=1.3257516} dielectric_loss_tangent{anisotropic component1=1 component2=1 component3=1} magnetic_loss_tangent{anisotropic component1=1 component2=1 component3=1}

design vivaldi_v2 (HFSS, DrivenModal, model units mm)
options: Save_Adaptive_support_files
variables:
  subTh = 1.633mm
  cuTh = 0.0432mm
  lambc = (3e8/1.55e9) meter
  subL = 110mm  # optimise 25mm..75mm
  subW = 120mm  # optimise 35mm..105mm
  w50 = 2.8mm  # optimise 1.75mm..5.25mm
  slot = 1mm
  w100 = 1.2mm
  lam4 = 30mm
  w70 = 1.5mm
  slotL = subL/2
  slotW = 3mm
  slotspc = 3mm
  offset = 2mm
  curve1y = 5mm
  curve2y = 5mm
  portoffset = 5mm
  slotoffset = 10mm
geometry:
  Box1 [FR408] = box(corner=(0mm, 0mm, 0mm), size=(subL, subW, subTh))
  Ellipse1 [pec] = ellipse(normal=Z, centre=(0mm, 0mm, subTh), major_radius=subW, ratio=(subL/2-slot/2)/subW)
  Ellipse1.rotate(axis=Z, angle=90deg)
  Rectangle1 = rectangle(corner=(0mm, 0mm, subTh), x_size=subL, y_size=subW)
  Ellipse1.intersect(Rectangle1)
  Ellipse2 [pec] = ellipse(normal=Z, centre=(0mm, 0mm, subTh), major_radius=subW, ratio=(subL/2-slot/2)/subW)
  Ellipse2.rotate(axis=Z, angle=90deg)
  Rectangle2 = rectangle(corner=(0mm, 0mm, subTh), x_size=subL, y_size=subW)
  Ellipse2.intersect(Rectangle2)
  Ellipse2.mirror(point=(subL/2, 0, 0), normal=(subL/2, 0, 0))
  [Ellipse2, Ellipse1].sweep_along_vector((0mm, 0mm, cuTh))
  Ellipse1.move(0mm, 0mm, -subTh-cuTh)
  Rectangle3 = rectangle(corner=(0, portoffset, 0mm), y_size=w50, z_size=subTh)
  RadiatingSurface [vacuum] = region(absolute_offset=48.387097mm on all sides)
  coordinate_system FaceCS1 = face of RadiatingSurface: Origin=RadiatingSurface.vertex(1 of 8) FaceID=RadiatingSurface.face(+z) AxisPosn=RadiatingSurface.vertex(2 of 8) WhichAxis=X ZRotationAngle=0deg XOffset=0mm YOffset=0mm
  PML_RadiatingSurface_1 [PMLGroup1_Z_9, oriented by FaceCS1] = sweep_along_normal(RadiatingSurface.face(+z), length=65.27906mm)
  coordinate_system FaceCS2 = face of RadiatingSurface: Origin=RadiatingSurface.vertex(5 of 8) FaceID=RadiatingSurface.face(-z) AxisPosn=RadiatingSurface.vertex(6 of 8) WhichAxis=X ZRotationAngle=0deg XOffset=0mm YOffset=0mm
  PML_RadiatingSurface_2 [PMLGroup1_Z_9, oriented by FaceCS2] = sweep_along_normal(RadiatingSurface.face(-z), length=65.27906mm)
  coordinate_system FaceCS3 = face of RadiatingSurface: Origin=RadiatingSurface.vertex(4 of 8) FaceID=RadiatingSurface.face(-y) AxisPosn=RadiatingSurface.vertex(7 of 8) WhichAxis=X ZRotationAngle=0deg XOffset=0mm YOffset=0mm
  PML_RadiatingSurface_3 [PMLGroup1_Z_9, oriented by FaceCS3] = sweep_along_normal(RadiatingSurface.face(-y), length=65.27906mm)
  coordinate_system FaceCS4 = face of RadiatingSurface: Origin=RadiatingSurface.vertex(3 of 8) FaceID=RadiatingSurface.face(-x) AxisPosn=RadiatingSurface.vertex(8 of 8) WhichAxis=X ZRotationAngle=0deg XOffset=0mm YOffset=0mm
  PML_RadiatingSurface_4 [PMLGroup1_Z_9, oriented by FaceCS4] = sweep_along_normal(RadiatingSurface.face(-x), length=65.27906mm)
  coordinate_system FaceCS5 = face of RadiatingSurface: Origin=RadiatingSurface.vertex(2 of 8) FaceID=RadiatingSurface.face(+y) AxisPosn=RadiatingSurface.vertex(5 of 8) WhichAxis=X ZRotationAngle=0deg XOffset=0mm YOffset=0mm
  PML_RadiatingSurface_5 [PMLGroup1_Z_9, oriented by FaceCS5] = sweep_along_normal(RadiatingSurface.face(+y), length=65.27906mm)
  coordinate_system FaceCS6 = face of RadiatingSurface: Origin=RadiatingSurface.vertex(1 of 8) FaceID=RadiatingSurface.face(+x) AxisPosn=RadiatingSurface.vertex(6 of 8) WhichAxis=X ZRotationAngle=0deg XOffset=0mm YOffset=0mm
  PML_RadiatingSurface_6 [PMLGroup1_Z_9, oriented by FaceCS6] = sweep_along_normal(RadiatingSurface.face(+x), length=65.27906mm)
  PML_RadiatingSurface_7 [PMLGroup1_XZ_9, oriented by FaceCS3] = sweep_along_normal(PML_RadiatingSurface_1.face(at (55, -48.3871, 82.7028)), length=65.27906mm)
  PML_RadiatingSurface_8 [PMLGroup1_XZ_9, oriented by FaceCS4] = sweep_along_normal(PML_RadiatingSurface_1.face(at (-48.3871, 60, 82.7028)), length=65.27906mm)
  PML_RadiatingSurface_9 [PMLGroup1_XZ_9, oriented by FaceCS5] = sweep_along_normal(PML_RadiatingSurface_1.face(at (55, 168.387, 82.7028)), length=65.27906mm)
  PML_RadiatingSurface_10 [PMLGroup1_YZ_9, oriented by FaceCS1] = sweep_along_normal(PML_RadiatingSurface_1.face(at (158.387, 60, 82.7028)), length=65.27906mm)
  coordinate_system FaceCS7 = face of RadiatingSurface: Origin=RadiatingSurface.vertex(6 of 8) FaceID=RadiatingSurface.face(-z) AxisPosn=RadiatingSurface.vertex(7 of 8) WhichAxis=X ZRotationAngle=0deg XOffset=0mm YOffset=0mm
  PML_RadiatingSurface_11 [PMLGroup1_YZ_9, oriented by FaceCS7] = sweep_along_normal(PML_RadiatingSurface_2.face(at (55, -48.3871, -81.0698)), length=65.27906mm)
  coordinate_system FaceCS8 = face of RadiatingSurface: Origin=RadiatingSurface.vertex(7 of 8) FaceID=RadiatingSurface.face(-z) AxisPosn=RadiatingSurface.vertex(8 of 8) WhichAxis=X ZRotationAngle=0deg XOffset=0mm YOffset=0mm
  PML_RadiatingSurface_12 [PMLGroup1_YZ_9, oriented by FaceCS8] = sweep_along_normal(PML_RadiatingSurface_2.face(at (-48.3871, 60, -81.0698)), length=65.27906mm)
  PML_RadiatingSurface_13 [PMLGroup1_XZ_9, oriented by FaceCS2] = sweep_along_normal(PML_RadiatingSurface_2.face(at (55, 168.387, -81.0698)), length=65.27906mm)
  PML_RadiatingSurface_14 [PMLGroup1_YZ_9, oriented by FaceCS2] = sweep_along_normal(PML_RadiatingSurface_2.face(at (158.387, 60, -81.0698)), length=65.27906mm)
  PML_RadiatingSurface_15 [PMLGroup1_YZ_9, oriented by FaceCS3] = sweep_along_normal(PML_RadiatingSurface_3.face(at (-48.3871, -81.0266, 0.8165)), length=65.27906mm)
  PML_RadiatingSurface_16 [PMLGroup1_YZ_9, oriented by FaceCS6] = sweep_along_normal(PML_RadiatingSurface_3.face(at (158.387, -81.0266, 0.8165)), length=65.27906mm)
  PML_RadiatingSurface_17 [PMLGroup1_YZ_9, oriented by FaceCS4] = sweep_along_normal(PML_RadiatingSurface_4.face(at (-81.0266, 168.387, 0.8165)), length=65.27906mm)
  PML_RadiatingSurface_18 [PMLGroup1_YZ_9, oriented by FaceCS5] = sweep_along_normal(PML_RadiatingSurface_5.face(at (158.387, 201.027, 0.8165)), length=65.27906mm)
  PML_RadiatingSurface_19 [PMLGroup1_XYZ_9, oriented by FaceCS3] = sweep_along_normal(PML_RadiatingSurface_7.face(at (-48.3871, -81.0266, 82.7028)), length=65.27906mm)
  PML_RadiatingSurface_20 [PMLGroup1_XYZ_9, oriented by FaceCS1] = sweep_along_normal(PML_RadiatingSurface_7.face(at (158.387, -81.0266, 82.7028)), length=65.27906mm)
  PML_RadiatingSurface_21 [PMLGroup1_XYZ_9, oriented by FaceCS4] = sweep_along_normal(PML_RadiatingSurface_8.face(at (-81.0266, 168.387, 82.7028)), length=65.27906mm)
  PML_RadiatingSurface_22 [PMLGroup1_XYZ_9, oriented by FaceCS5] = sweep_along_normal(PML_RadiatingSurface_9.face(at (158.387, 201.027, 82.7028)), length=65.27906mm)
  PML_RadiatingSurface_23 [PMLGroup1_XYZ_9, oriented by FaceCS8] = sweep_along_normal(PML_RadiatingSurface_11.face(at (-48.3871, -81.0266, -81.0698)), length=65.27906mm)
  PML_RadiatingSurface_24 [PMLGroup1_XYZ_9, oriented by FaceCS7] = sweep_along_normal(PML_RadiatingSurface_11.face(at (158.387, -81.0266, -81.0698)), length=65.27906mm)
  coordinate_system FaceCS9 = face of RadiatingSurface: Origin=RadiatingSurface.vertex(8 of 8) FaceID=RadiatingSurface.face(-z) AxisPosn=RadiatingSurface.vertex(5 of 8) WhichAxis=X ZRotationAngle=0deg XOffset=0mm YOffset=0mm
  PML_RadiatingSurface_25 [PMLGroup1_XYZ_9, oriented by FaceCS9] = sweep_along_normal(PML_RadiatingSurface_12.face(at (-81.0266, 168.387, -81.0698)), length=65.27906mm)
  PML_RadiatingSurface_26 [PMLGroup1_XYZ_9, oriented by FaceCS2] = sweep_along_normal(PML_RadiatingSurface_13.face(at (158.387, 201.027, -81.0698)), length=65.27906mm)
  Box3 = box(corner=(0mm, portoffset, subTh), size=(lam4, w50, cuTh))
  Box4 = box(corner=(lam4+portoffset+w50/2-w70/2, 0mm, subTh), size=(lam4, w70, cuTh))
  Box5 = box(corner=(0mm, 10mm, 0mm), size=(slotL, slotW, -cuTh))
  Ellipse3 = ellipse(normal=Z, centre=(0mm, 0mm, subTh), major_radius=subW-offset, ratio=(subL/2-slot/2-offset)/(subW-offset))
  Ellipse3.rotate(axis=Z, angle=90deg)
  Rectangle4 = rectangle(corner=(0mm, 0mm, subTh), x_size=subL, y_size=subW)
  Ellipse3.intersect(Rectangle4)
  Ellipse3.sweep_along_vector((0mm, 0mm, cuTh))
  Ellipse3.move(0mm, 0mm, -subTh-cuTh)
  Box5.duplicate_along_line(step=(0mm, slotspc+slotW, 0mm), total=30, attached)
  Box5.intersect(Ellipse3)
  Box5_1 = Box5.duplicate_mirror(point=(subL/2, 0mm, 0mm), normal=(subL/2, 0mm, 0mm))
  Box5_1.move(0mm, 0mm, subTh+cuTh)
  Ellipse1.subtract(Box5)
  Ellipse2.subtract(Box5_1)
  Polyline1 = polyline((lam4, portoffset+w50/2, subTh+cuTh) (32.227386mm, 5.4773864mm, 1.6762mm) (33.15mm, 3.25mm, 1.6762mm), AngularArc from point 0 over 3 centre=(lam4, portoffset/2+w70/2, subTh+cuTh) angle=-90deg plane=XY, section rectangle width=w70 height=0mm)
  Polyline1.thicken(-cuTh)
  Box8 = box(corner=(0mm, 0mm, 0mm), size=(subL/2, portoffset+slotoffset, -cuTh))
  Ellipse4 = ellipse(normal=Z, centre=(0mm, 0mm, subTh), major_radius=subW, ratio=(subL/2-slot/2)/subW)
  Ellipse4.rotate(axis=Z, angle=90deg)
  Rectangle5 = rectangle(corner=(0mm, 0mm, subTh), x_size=subL, y_size=subW)
  Ellipse4.intersect(Rectangle5)
  Ellipse4.sweep_along_vector((0mm, 0mm, cuTh))
  Ellipse4.move(0mm, 0mm, -subTh-cuTh)
  Ellipse4.intersect(Box8)
  Ellipse1.unite(Ellipse4)
  Ellipse5 = ellipse(normal=Z, centre=(0mm, 0mm, subTh), major_radius=subW, ratio=(subL/2-slot/2)/subW)
  Ellipse5.rotate(axis=Z, angle=90deg)
  Rectangle6 = rectangle(corner=(0mm, 0mm, subTh), x_size=subL, y_size=subW)
  Ellipse5.intersect(Rectangle6)
  Ellipse5.sweep_along_vector((0mm, 0mm, cuTh))
  Ellipse5.move(0mm, 0mm, -subTh-cuTh)
  Box9 = box(corner=(0mm, 0mm, 0mm), size=(subL/2, portoffset+slotoffset, -cuTh))
  Ellipse5.intersect(Box9)
  Ellipse5.mirror(point=(subL/2, 0mm, 0mm), normal=(subL/2, 0mm, 0mm))
  Ellipse5.move(0mm, 0mm, subTh+cuTh)
  Ellipse2.unite(Ellipse5)
  Polyline2 = polyline((lam4+portoffset/2+w50/2-w70/2, portoffset/2+w70/2, subTh+cuTh) (33.882233mm, 1.482233mm, 1.6762mm) (35.65mm, 0.75mm, 1.6762mm), AngularArc from point 0 over 3 centre=(lam4+portoffset+w50/2-w70/2, portoffset/2+w70/2, subTh+cuTh) angle=90deg plane=XY, section rectangle width=w70 height=0mm)
  Polyline2.thicken(cuTh)
  Box3.unite(Box4, Polyline1, Polyline2)
  Ellipse2.unite(Box3)
boundaries and excitations:
  PML_radiation1: Radiation Faces=RadiatingSurface.face(+z) IsForPML
  PML_radiation2: Radiation Faces=RadiatingSurface.face(-z) IsForPML
  PML_radiation3: Radiation Faces=RadiatingSurface.face(-y) IsForPML
  PML_radiation4: Radiation Faces=RadiatingSurface.face(-x) IsForPML
  PML_radiation5: Radiation Faces=RadiatingSurface.face(+y) IsForPML
  PML_radiation6: Radiation Faces=RadiatingSurface.face(+x) IsForPML
  1: Lumped Port Objects=Rectangle3 Modes{Mode1{IntLine{middle of Rectangle3.edge(z at corner) -> middle of Rectangle3.edge(z opposite corner)} CharImp=Zpi RenormImp=50ohm}} Impedance=50ohm
setups:
  Setup1: HfssDrivenAuto AutoSolverSetting=Balanced Type=Interpolating
    sweep Sweep: 0GHz to 5GHz, 501 points;
  Setup2: HfssDrivenAuto AutoSolverSetting="Higher Accuracy" Type=Interpolating
    sweep Sweep: 0GHz to 4GHz, 401 points;
source amplitudes:
  1:1: 1W 0deg
optimetrics:
  ParametricSetup1: Parametric Sim._Setups=[Setup1]
    sweep subL: 110mm
    sweep w70: LIN 1.4mm 1.9mm 0.1mm
    sweep w50: LIN 2.6mm 3mm 0.1mm
radiation setups:
  3D: Infinite Sphere Theta=0deg..180deg step 2deg Phi=-180deg..180deg step 2deg
  Elevation: Infinite Sphere Theta=-180deg..180deg step 1deg Phi=0deg..90deg step 90deg
  Azimuth: Infinite Sphere Theta=90deg..90deg step 0deg Phi=-180deg..180deg step 1deg
reports:
  S Parameter Plot 1: dB(S(1,1)) vs Freq on Setup1 : Sweep [subL=all]
  Gain Plot 1: dB(GainTotal) vs Phi on Setup1 : Sweep, 3D [Theta=90deg Freq=1.125GHz,1.5GHz,1.75GHz,3GHz subL=110mm w50=2.8mm w70=1.5mm]; markers m1 at 90deg
  Gain Plot 2: dB(GainTotal) vs Theta on Setup1 : Sweep, 3D [Phi=90deg Freq=1.25GHz,1.5GHz,1.75GHz,3GHz subL=110mm w50=2.8mm w70=1.5mm]
  S Parameter Plot 4: dB(S(1,1)) vs Freq on Setup2 : Sweep; markers m1 at 1.12GHz
  Theta90: dB(GainTotal) vs Phi on Setup2 : Sweep, 3D [Theta=90deg Freq=1.31875GHz,1.5625GHz,1.80625GHz,3.025GHz subL=all w50=all w70=all]
  Phi90: dB(GainTotal) vs Theta on Setup2 : Sweep, 3D [Phi=90deg Freq=1.31875GHz,1.5625GHz,1.80625GHz subL=all w50=all w70=all]
  Phim90: dB(GainTotal) vs Theta on Setup2 : Sweep, 3D [Phi=-90deg Freq=1.31875GHz,1.5625GHz,1.80625GHz subL=all w50=all w70=all]
